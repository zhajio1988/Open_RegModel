field swcfg_field {
     hw   = r; sw = rw;
     desc = "SW Configuration field";
};

regfile regs_ral_demo{
    default regwidth=32;

    reg {
        name = "Control Register";
        desc = "
////Convolution MAC array Registers
";        
        field {
            sw              = r;
            hw              = w;
            reset           = 0x0;
        } PRESCALER[1:0] = 0;
        PRESCALER->desc="
//// Status of configuration register group 0
";        
        field {
            sw              = r;
            hw              = w;
            reset           = 0x0;
        } MODE[3:2] = 0;
        
        field {
            hw=rw; we;
        } MASTER[4:4] = 0;
        MASTER->desc = "Selects master mode when written to one, and slave mode when
            written to zero. If SS is configured as an input and driven low while
            master mode is set, master mode will be cleared";        
        field {
            desc = "DORD decides the data order when a byte is shifted out from
            the DATA register. When DORD is written to one, the least-significant
            bit (lsb) of the data byte is transmitted first, and when DORD is
            written to zero, the most-significant bit (msb) of the data byte is
            transmitted first";
        } DORD[5:5] = 0;
        
        field {
            desc = "Setting this bit enables the SPI module. This bit must be
            set to enable any SPI operations";
        } ENABLE[6:6] = 0;
        
        field {
            desc = "When this bit is set, the SPI speed (SCK frequency) will be
            doubled in master mode";
        } CLK2X[7:7] = 0;
    } CTRL @0x0;
    
    reg {
        name = "Interrupt Control";
        
        field {
            desc = "These bits enable the SPI interrupt and select the interrupt level";
        } INTLVL[1:0] = 0;
    } INTCTRL @ 0x4;
    
    reg {
        field {
            sw=r; hw=rw; we;
        } WRCOL[6:6] = 0;
        
        field {
            sw=r; hw=rw; we;
        } IF[7:7] = 0;
    } STATUS @0x8;

    reg {
        swcfg_field en[31:31] = 1'd1;
        field {rclr; hw=w; we; } subch[30:26] = 5'd0;
        field {rclr; hw=w; we; 
              } str[25:16] = 10'd0;
    } RCNT_SAT @0xc;      
    
};

addrmap  addrmap_top{
    name = "ATXMEGA SPI controller";
    desc = "Register description of Atmel XMEGA AU's SPI controller
    Transcribed from original manual as an example exercise:
    http://ww1.microchip.com/downloads/en/DeviceDoc/Atmel-8331-8-and-16-bit-AVR-Microcontroller-XMEGA-AU_Manual.pdf";
    signal { activelow; field_reset; cpuif_reset;} reset_n;
    regs_ral_demo ral_regs_demo @0x0;
} addrmap_hwa_wrapper;
